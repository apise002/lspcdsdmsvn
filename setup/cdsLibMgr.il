; cdsLibMgr.il
load(strcat(getShellEnvVar("LSPCDSDMSVN_HOME") "/skill/cdsdm_menu_cdsLibMgr.il"))
